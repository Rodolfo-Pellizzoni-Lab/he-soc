// Copyright 2023 ETH Zurich and University of Bologna.
// Solderpad Hardware License, Version 0.51, see LICENSE for details.
// SPDX-License-Identifier: SHL-0.51
// Luca Valente <luca.valente@unibo.it>
{
  name: "hyper_pad",
  clock_primary: "clk_i",
  reset_primary: "rst_ni"
  bus_interfaces: [
    { protocol: "reg_iface", direction: "device" }
  ],
  regwidth: "32",
  registers :[
            { multireg :
                       { name: "PADs",
                         desc: "pad configuration",
                         count: "32",
                         cname: "cfg",
                         swaccess: "rw",
                         fields: [
                           { bits: "0" ,
                             name: "SMT",
                             desc: "SMT",
                             swaccess: "rw",
                             hwaccess: "hro",
                             resval: "0"
                           }
                           { bits: "1" ,
                             swaccess: "rw",
                             hwaccess: "hro",
                             resval: "0",
                             name: "SLW",
                             desc: "SLW",
                           }
                           { bits: "3:2" ,
                             swaccess: "rw",
                             hwaccess: "hro",
                             resval: "0",
                             name: "DRV",
                             desc: "Drive strength"
                           }
                         ],
                       }
            }
  ],
}
